* Auto-Synthesized CMOS Circuit
* Flat topography for Carry Lookahead ALU.

M1    n2         B1         VDD        VDD        PMOS
M2    n2         S1         VDD        VDD        PMOS
M3    n2         B1         n3         GND        NMOS
M4    n3         S1         GND        GND        NMOS
M5    n1         n2         VDD        VDD        PMOS
M6    n1         n2         GND        GND        NMOS
M7    n6         A1         VDD        VDD        PMOS
M8    n5         n1         n6         VDD        PMOS
M9    n5         A1         GND        GND        NMOS
M10   n5         n1         GND        GND        NMOS
M11   n4         n5         VDD        VDD        PMOS
M12   n4         n5         GND        GND        NMOS
M13   n7         B1         VDD        VDD        PMOS
M14   n7         B1         GND        GND        NMOS
M15   n9         n7         VDD        VDD        PMOS
M16   n9         S0         VDD        VDD        PMOS
M17   n9         n7         n10        GND        NMOS
M18   n10        S0         GND        GND        NMOS
M19   n8         n9         VDD        VDD        PMOS
M20   n8         n9         GND        GND        NMOS
M21   n13        n4         VDD        VDD        PMOS
M22   n12        n8         n13        VDD        PMOS
M23   n12        n4         GND        GND        NMOS
M24   n12        n8         GND        GND        NMOS
M25   n11        n12        VDD        VDD        PMOS
M26   n11        n12        GND        GND        NMOS
M27   n14        n11        VDD        VDD        PMOS
M28   n14        n11        GND        GND        NMOS
M29   n15        n14        VDD        VDD        PMOS
M30   n15        n14        GND        GND        NMOS
M31   P1         n15        VDD        VDD        PMOS
M32   P1         n15        GND        GND        NMOS
M33   n16        Cn         VDD        VDD        PMOS
M34   n16        Cn         GND        GND        NMOS
M35   n19        n16        VDD        VDD        PMOS
M36   n18        M          n19        VDD        PMOS
M37   n18        n16        GND        GND        NMOS
M38   n18        M          GND        GND        NMOS
M39   n17        n18        VDD        VDD        PMOS
M40   n17        n18        GND        GND        NMOS
M41   n20        n17        VDD        VDD        PMOS
M42   n20        n17        GND        GND        NMOS
M43   n21        n20        VDD        VDD        PMOS
M44   n21        n20        GND        GND        NMOS
M45   C0         n21        VDD        VDD        PMOS
M46   C0         n21        GND        GND        NMOS
M47   n23        A1         VDD        VDD        PMOS
M48   n23        B1         VDD        VDD        PMOS
M49   n23        A1         n24        GND        NMOS
M50   n24        B1         GND        GND        NMOS
M51   n22        n23        VDD        VDD        PMOS
M52   n22        n23        GND        GND        NMOS
M53   n26        n22        VDD        VDD        PMOS
M54   n26        S3         VDD        VDD        PMOS
M55   n26        n22        n27        GND        NMOS
M56   n27        S3         GND        GND        NMOS
M57   n25        n26        VDD        VDD        PMOS
M58   n25        n26        GND        GND        NMOS
M59   n28        B1         VDD        VDD        PMOS
M60   n28        B1         GND        GND        NMOS
M61   n30        n28        VDD        VDD        PMOS
M62   n30        S2         VDD        VDD        PMOS
M63   n30        n28        n31        GND        NMOS
M64   n31        S2         GND        GND        NMOS
M65   n29        n30        VDD        VDD        PMOS
M66   n29        n30        GND        GND        NMOS
M67   n33        A1         VDD        VDD        PMOS
M68   n33        n29        VDD        VDD        PMOS
M69   n33        A1         n34        GND        NMOS
M70   n34        n29        GND        GND        NMOS
M71   n32        n33        VDD        VDD        PMOS
M72   n32        n33        GND        GND        NMOS
M73   n37        n25        VDD        VDD        PMOS
M74   n36        n32        n37        VDD        PMOS
M75   n36        n25        GND        GND        NMOS
M76   n36        n32        GND        GND        NMOS
M77   n35        n36        VDD        VDD        PMOS
M78   n35        n36        GND        GND        NMOS
M79   n38        n35        VDD        VDD        PMOS
M80   n38        n35        GND        GND        NMOS
M81   n39        n38        VDD        VDD        PMOS
M82   n39        n38        GND        GND        NMOS
M83   G1         n39        VDD        VDD        PMOS
M84   G1         n39        GND        GND        NMOS
M85   n41        A3         VDD        VDD        PMOS
M86   n41        B3         VDD        VDD        PMOS
M87   n41        A3         n42        GND        NMOS
M88   n42        B3         GND        GND        NMOS
M89   n40        n41        VDD        VDD        PMOS
M90   n40        n41        GND        GND        NMOS
M91   n44        n40        VDD        VDD        PMOS
M92   n44        S3         VDD        VDD        PMOS
M93   n44        n40        n45        GND        NMOS
M94   n45        S3         GND        GND        NMOS
M95   n43        n44        VDD        VDD        PMOS
M96   n43        n44        GND        GND        NMOS
M97   n46        B3         VDD        VDD        PMOS
M98   n46        B3         GND        GND        NMOS
M99   n48        n46        VDD        VDD        PMOS
M100  n48        S2         VDD        VDD        PMOS
M101  n48        n46        n49        GND        NMOS
M102  n49        S2         GND        GND        NMOS
M103  n47        n48        VDD        VDD        PMOS
M104  n47        n48        GND        GND        NMOS
M105  n51        A3         VDD        VDD        PMOS
M106  n51        n47        VDD        VDD        PMOS
M107  n51        A3         n52        GND        NMOS
M108  n52        n47        GND        GND        NMOS
M109  n50        n51        VDD        VDD        PMOS
M110  n50        n51        GND        GND        NMOS
M111  n55        n43        VDD        VDD        PMOS
M112  n54        n50        n55        VDD        PMOS
M113  n54        n43        GND        GND        NMOS
M114  n54        n50        GND        GND        NMOS
M115  n53        n54        VDD        VDD        PMOS
M116  n53        n54        GND        GND        NMOS
M117  n56        n53        VDD        VDD        PMOS
M118  n56        n53        GND        GND        NMOS
M119  n57        n56        VDD        VDD        PMOS
M120  n57        n56        GND        GND        NMOS
M121  G3         n57        VDD        VDD        PMOS
M122  G3         n57        GND        GND        NMOS
M123  n59        B3         VDD        VDD        PMOS
M124  n59        S1         VDD        VDD        PMOS
M125  n59        B3         n60        GND        NMOS
M126  n60        S1         GND        GND        NMOS
M127  n58        n59        VDD        VDD        PMOS
M128  n58        n59        GND        GND        NMOS
M129  n63        A3         VDD        VDD        PMOS
M130  n62        n58        n63        VDD        PMOS
M131  n62        A3         GND        GND        NMOS
M132  n62        n58        GND        GND        NMOS
M133  n61        n62        VDD        VDD        PMOS
M134  n61        n62        GND        GND        NMOS
M135  n64        B3         VDD        VDD        PMOS
M136  n64        B3         GND        GND        NMOS
M137  n66        n64        VDD        VDD        PMOS
M138  n66        S0         VDD        VDD        PMOS
M139  n66        n64        n67        GND        NMOS
M140  n67        S0         GND        GND        NMOS
M141  n65        n66        VDD        VDD        PMOS
M142  n65        n66        GND        GND        NMOS
M143  n70        n61        VDD        VDD        PMOS
M144  n69        n65        n70        VDD        PMOS
M145  n69        n61        GND        GND        NMOS
M146  n69        n65        GND        GND        NMOS
M147  n68        n69        VDD        VDD        PMOS
M148  n68        n69        GND        GND        NMOS
M149  n71        n68        VDD        VDD        PMOS
M150  n71        n68        GND        GND        NMOS
M151  n72        n71        VDD        VDD        PMOS
M152  n72        n71        GND        GND        NMOS
M153  P3         n72        VDD        VDD        PMOS
M154  P3         n72        GND        GND        NMOS
M155  n74        B0         VDD        VDD        PMOS
M156  n74        S1         VDD        VDD        PMOS
M157  n74        B0         n75        GND        NMOS
M158  n75        S1         GND        GND        NMOS
M159  n73        n74        VDD        VDD        PMOS
M160  n73        n74        GND        GND        NMOS
M161  n78        A0         VDD        VDD        PMOS
M162  n77        n73        n78        VDD        PMOS
M163  n77        A0         GND        GND        NMOS
M164  n77        n73        GND        GND        NMOS
M165  n76        n77        VDD        VDD        PMOS
M166  n76        n77        GND        GND        NMOS
M167  n79        B0         VDD        VDD        PMOS
M168  n79        B0         GND        GND        NMOS
M169  n81        n79        VDD        VDD        PMOS
M170  n81        S0         VDD        VDD        PMOS
M171  n81        n79        n82        GND        NMOS
M172  n82        S0         GND        GND        NMOS
M173  n80        n81        VDD        VDD        PMOS
M174  n80        n81        GND        GND        NMOS
M175  n85        n76        VDD        VDD        PMOS
M176  n84        n80        n85        VDD        PMOS
M177  n84        n76        GND        GND        NMOS
M178  n84        n80        GND        GND        NMOS
M179  n83        n84        VDD        VDD        PMOS
M180  n83        n84        GND        GND        NMOS
M181  n86        n83        VDD        VDD        PMOS
M182  n86        n83        GND        GND        NMOS
M183  n87        n86        VDD        VDD        PMOS
M184  n87        n86        GND        GND        NMOS
M185  P0         n87        VDD        VDD        PMOS
M186  P0         n87        GND        GND        NMOS
M187  n89        A2         VDD        VDD        PMOS
M188  n89        B2         VDD        VDD        PMOS
M189  n89        A2         n90        GND        NMOS
M190  n90        B2         GND        GND        NMOS
M191  n88        n89        VDD        VDD        PMOS
M192  n88        n89        GND        GND        NMOS
M193  n92        n88        VDD        VDD        PMOS
M194  n92        S3         VDD        VDD        PMOS
M195  n92        n88        n93        GND        NMOS
M196  n93        S3         GND        GND        NMOS
M197  n91        n92        VDD        VDD        PMOS
M198  n91        n92        GND        GND        NMOS
M199  n94        B2         VDD        VDD        PMOS
M200  n94        B2         GND        GND        NMOS
M201  n96        n94        VDD        VDD        PMOS
M202  n96        S2         VDD        VDD        PMOS
M203  n96        n94        n97        GND        NMOS
M204  n97        S2         GND        GND        NMOS
M205  n95        n96        VDD        VDD        PMOS
M206  n95        n96        GND        GND        NMOS
M207  n99        A2         VDD        VDD        PMOS
M208  n99        n95        VDD        VDD        PMOS
M209  n99        A2         n100       GND        NMOS
M210  n100       n95        GND        GND        NMOS
M211  n98        n99        VDD        VDD        PMOS
M212  n98        n99        GND        GND        NMOS
M213  n103       n91        VDD        VDD        PMOS
M214  n102       n98        n103       VDD        PMOS
M215  n102       n91        GND        GND        NMOS
M216  n102       n98        GND        GND        NMOS
M217  n101       n102       VDD        VDD        PMOS
M218  n101       n102       GND        GND        NMOS
M219  n104       n101       VDD        VDD        PMOS
M220  n104       n101       GND        GND        NMOS
M221  n105       n104       VDD        VDD        PMOS
M222  n105       n104       GND        GND        NMOS
M223  G2         n105       VDD        VDD        PMOS
M224  G2         n105       GND        GND        NMOS
M225  n107       B2         VDD        VDD        PMOS
M226  n107       S1         VDD        VDD        PMOS
M227  n107       B2         n108       GND        NMOS
M228  n108       S1         GND        GND        NMOS
M229  n106       n107       VDD        VDD        PMOS
M230  n106       n107       GND        GND        NMOS
M231  n111       A2         VDD        VDD        PMOS
M232  n110       n106       n111       VDD        PMOS
M233  n110       A2         GND        GND        NMOS
M234  n110       n106       GND        GND        NMOS
M235  n109       n110       VDD        VDD        PMOS
M236  n109       n110       GND        GND        NMOS
M237  n112       B2         VDD        VDD        PMOS
M238  n112       B2         GND        GND        NMOS
M239  n114       n112       VDD        VDD        PMOS
M240  n114       S0         VDD        VDD        PMOS
M241  n114       n112       n115       GND        NMOS
M242  n115       S0         GND        GND        NMOS
M243  n113       n114       VDD        VDD        PMOS
M244  n113       n114       GND        GND        NMOS
M245  n118       n109       VDD        VDD        PMOS
M246  n117       n113       n118       VDD        PMOS
M247  n117       n109       GND        GND        NMOS
M248  n117       n113       GND        GND        NMOS
M249  n116       n117       VDD        VDD        PMOS
M250  n116       n117       GND        GND        NMOS
M251  n119       n116       VDD        VDD        PMOS
M252  n119       n116       GND        GND        NMOS
M253  n120       n119       VDD        VDD        PMOS
M254  n120       n119       GND        GND        NMOS
M255  P2         n120       VDD        VDD        PMOS
M256  P2         n120       GND        GND        NMOS
M257  n122       A0         VDD        VDD        PMOS
M258  n122       B0         VDD        VDD        PMOS
M259  n122       A0         n123       GND        NMOS
M260  n123       B0         GND        GND        NMOS
M261  n121       n122       VDD        VDD        PMOS
M262  n121       n122       GND        GND        NMOS
M263  n125       n121       VDD        VDD        PMOS
M264  n125       S3         VDD        VDD        PMOS
M265  n125       n121       n126       GND        NMOS
M266  n126       S3         GND        GND        NMOS
M267  n124       n125       VDD        VDD        PMOS
M268  n124       n125       GND        GND        NMOS
M269  n127       B0         VDD        VDD        PMOS
M270  n127       B0         GND        GND        NMOS
M271  n129       n127       VDD        VDD        PMOS
M272  n129       S2         VDD        VDD        PMOS
M273  n129       n127       n130       GND        NMOS
M274  n130       S2         GND        GND        NMOS
M275  n128       n129       VDD        VDD        PMOS
M276  n128       n129       GND        GND        NMOS
M277  n132       A0         VDD        VDD        PMOS
M278  n132       n128       VDD        VDD        PMOS
M279  n132       A0         n133       GND        NMOS
M280  n133       n128       GND        GND        NMOS
M281  n131       n132       VDD        VDD        PMOS
M282  n131       n132       GND        GND        NMOS
M283  n136       n124       VDD        VDD        PMOS
M284  n135       n131       n136       VDD        PMOS
M285  n135       n124       GND        GND        NMOS
M286  n135       n131       GND        GND        NMOS
M287  n134       n135       VDD        VDD        PMOS
M288  n134       n135       GND        GND        NMOS
M289  n137       n134       VDD        VDD        PMOS
M290  n137       n134       GND        GND        NMOS
M291  n138       n137       VDD        VDD        PMOS
M292  n138       n137       GND        GND        NMOS
M293  G0         n138       VDD        VDD        PMOS
M294  G0         n138       GND        GND        NMOS
M295  n141       M          VDD        VDD        PMOS
M296  n140       G1         n141       VDD        PMOS
M297  n140       M          GND        GND        NMOS
M298  n140       G1         GND        GND        NMOS
M299  n139       n140       VDD        VDD        PMOS
M300  n139       n140       GND        GND        NMOS
M301  n143       P1         VDD        VDD        PMOS
M302  n143       G0         VDD        VDD        PMOS
M303  n143       P1         n144       GND        NMOS
M304  n144       G0         GND        GND        NMOS
M305  n142       n143       VDD        VDD        PMOS
M306  n142       n143       GND        GND        NMOS
M307  n147       n139       VDD        VDD        PMOS
M308  n146       n142       n147       VDD        PMOS
M309  n146       n139       GND        GND        NMOS
M310  n146       n142       GND        GND        NMOS
M311  n145       n146       VDD        VDD        PMOS
M312  n145       n146       GND        GND        NMOS
M313  n149       P1         VDD        VDD        PMOS
M314  n149       P0         VDD        VDD        PMOS
M315  n149       P1         n150       GND        NMOS
M316  n150       P0         GND        GND        NMOS
M317  n148       n149       VDD        VDD        PMOS
M318  n148       n149       GND        GND        NMOS
M319  n151       Cn         VDD        VDD        PMOS
M320  n151       Cn         GND        GND        NMOS
M321  n153       n148       VDD        VDD        PMOS
M322  n153       n151       VDD        VDD        PMOS
M323  n153       n148       n154       GND        NMOS
M324  n154       n151       GND        GND        NMOS
M325  n152       n153       VDD        VDD        PMOS
M326  n152       n153       GND        GND        NMOS
M327  n157       n145       VDD        VDD        PMOS
M328  n156       n152       n157       VDD        PMOS
M329  n156       n145       GND        GND        NMOS
M330  n156       n152       GND        GND        NMOS
M331  n155       n156       VDD        VDD        PMOS
M332  n155       n156       GND        GND        NMOS
M333  n158       n155       VDD        VDD        PMOS
M334  n158       n155       GND        GND        NMOS
M335  n159       n158       VDD        VDD        PMOS
M336  n159       n158       GND        GND        NMOS
M337  C2         n159       VDD        VDD        PMOS
M338  C2         n159       GND        GND        NMOS
M339  n161       P0         VDD        VDD        PMOS
M340  n161       P1         VDD        VDD        PMOS
M341  n161       P0         n162       GND        NMOS
M342  n162       P1         GND        GND        NMOS
M343  n160       n161       VDD        VDD        PMOS
M344  n160       n161       GND        GND        NMOS
M345  n164       n160       VDD        VDD        PMOS
M346  n164       P2         VDD        VDD        PMOS
M347  n164       n160       n165       GND        NMOS
M348  n165       P2         GND        GND        NMOS
M349  n163       n164       VDD        VDD        PMOS
M350  n163       n164       GND        GND        NMOS
M351  n167       n163       VDD        VDD        PMOS
M352  n167       P3         VDD        VDD        PMOS
M353  n167       n163       n168       GND        NMOS
M354  n168       P3         GND        GND        NMOS
M355  n166       n167       VDD        VDD        PMOS
M356  n166       n167       GND        GND        NMOS
M357  n169       n166       VDD        VDD        PMOS
M358  n169       n166       GND        GND        NMOS
M359  n170       n169       VDD        VDD        PMOS
M360  n170       n169       GND        GND        NMOS
M361  X_OUT      n170       VDD        VDD        PMOS
M362  X_OUT      n170       GND        GND        NMOS
M363  n172       P0         VDD        VDD        PMOS
M364  n172       C0         VDD        VDD        PMOS
M365  n172       P0         n175       GND        NMOS
M366  n175       C0         GND        GND        NMOS
M367  n173       P0         VDD        VDD        PMOS
M368  n173       n172       VDD        VDD        PMOS
M369  n173       P0         n176       GND        NMOS
M370  n176       n172       GND        GND        NMOS
M371  n174       C0         VDD        VDD        PMOS
M372  n174       n172       VDD        VDD        PMOS
M373  n174       C0         n177       GND        NMOS
M374  n177       n172       GND        GND        NMOS
M375  n171       n173       VDD        VDD        PMOS
M376  n171       n174       VDD        VDD        PMOS
M377  n171       n173       n178       GND        NMOS
M378  n178       n174       GND        GND        NMOS
M379  n179       n171       VDD        VDD        PMOS
M380  n179       n171       GND        GND        NMOS
M381  F0         n179       VDD        VDD        PMOS
M382  F0         n179       GND        GND        NMOS
M383  n181       P3         VDD        VDD        PMOS
M384  n181       G2         VDD        VDD        PMOS
M385  n181       P3         n182       GND        NMOS
M386  n182       G2         GND        GND        NMOS
M387  n180       n181       VDD        VDD        PMOS
M388  n180       n181       GND        GND        NMOS
M389  n185       G3         VDD        VDD        PMOS
M390  n184       n180       n185       VDD        PMOS
M391  n184       G3         GND        GND        NMOS
M392  n184       n180       GND        GND        NMOS
M393  n183       n184       VDD        VDD        PMOS
M394  n183       n184       GND        GND        NMOS
M395  n187       P3         VDD        VDD        PMOS
M396  n187       P2         VDD        VDD        PMOS
M397  n187       P3         n188       GND        NMOS
M398  n188       P2         GND        GND        NMOS
M399  n186       n187       VDD        VDD        PMOS
M400  n186       n187       GND        GND        NMOS
M401  n190       n186       VDD        VDD        PMOS
M402  n190       G1         VDD        VDD        PMOS
M403  n190       n186       n191       GND        NMOS
M404  n191       G1         GND        GND        NMOS
M405  n189       n190       VDD        VDD        PMOS
M406  n189       n190       GND        GND        NMOS
M407  n194       n183       VDD        VDD        PMOS
M408  n193       n189       n194       VDD        PMOS
M409  n193       n183       GND        GND        NMOS
M410  n193       n189       GND        GND        NMOS
M411  n192       n193       VDD        VDD        PMOS
M412  n192       n193       GND        GND        NMOS
M413  n196       P3         VDD        VDD        PMOS
M414  n196       P2         VDD        VDD        PMOS
M415  n196       P3         n197       GND        NMOS
M416  n197       P2         GND        GND        NMOS
M417  n195       n196       VDD        VDD        PMOS
M418  n195       n196       GND        GND        NMOS
M419  n199       n195       VDD        VDD        PMOS
M420  n199       P1         VDD        VDD        PMOS
M421  n199       n195       n200       GND        NMOS
M422  n200       P1         GND        GND        NMOS
M423  n198       n199       VDD        VDD        PMOS
M424  n198       n199       GND        GND        NMOS
M425  n202       n198       VDD        VDD        PMOS
M426  n202       G0         VDD        VDD        PMOS
M427  n202       n198       n203       GND        NMOS
M428  n203       G0         GND        GND        NMOS
M429  n201       n202       VDD        VDD        PMOS
M430  n201       n202       GND        GND        NMOS
M431  n206       n192       VDD        VDD        PMOS
M432  n205       n201       n206       VDD        PMOS
M433  n205       n192       GND        GND        NMOS
M434  n205       n201       GND        GND        NMOS
M435  n204       n205       VDD        VDD        PMOS
M436  n204       n205       GND        GND        NMOS
M437  n208       P3         VDD        VDD        PMOS
M438  n208       P2         VDD        VDD        PMOS
M439  n208       P3         n209       GND        NMOS
M440  n209       P2         GND        GND        NMOS
M441  n207       n208       VDD        VDD        PMOS
M442  n207       n208       GND        GND        NMOS
M443  n211       n207       VDD        VDD        PMOS
M444  n211       P1         VDD        VDD        PMOS
M445  n211       n207       n212       GND        NMOS
M446  n212       P1         GND        GND        NMOS
M447  n210       n211       VDD        VDD        PMOS
M448  n210       n211       GND        GND        NMOS
M449  n214       n210       VDD        VDD        PMOS
M450  n214       P0         VDD        VDD        PMOS
M451  n214       n210       n215       GND        NMOS
M452  n215       P0         GND        GND        NMOS
M453  n213       n214       VDD        VDD        PMOS
M454  n213       n214       GND        GND        NMOS
M455  n216       Cn         VDD        VDD        PMOS
M456  n216       Cn         GND        GND        NMOS
M457  n218       n213       VDD        VDD        PMOS
M458  n218       n216       VDD        VDD        PMOS
M459  n218       n213       n219       GND        NMOS
M460  n219       n216       GND        GND        NMOS
M461  n217       n218       VDD        VDD        PMOS
M462  n217       n218       GND        GND        NMOS
M463  n222       n204       VDD        VDD        PMOS
M464  n221       n217       n222       VDD        PMOS
M465  n221       n204       GND        GND        NMOS
M466  n221       n217       GND        GND        NMOS
M467  n220       n221       VDD        VDD        PMOS
M468  n220       n221       GND        GND        NMOS
M469  n223       n220       VDD        VDD        PMOS
M470  n223       n220       GND        GND        NMOS
M471  n224       n223       VDD        VDD        PMOS
M472  n224       n223       GND        GND        NMOS
M473  Cn4_OUT    n224       VDD        VDD        PMOS
M474  Cn4_OUT    n224       GND        GND        NMOS
M475  n227       M          VDD        VDD        PMOS
M476  n226       G2         n227       VDD        PMOS
M477  n226       M          GND        GND        NMOS
M478  n226       G2         GND        GND        NMOS
M479  n225       n226       VDD        VDD        PMOS
M480  n225       n226       GND        GND        NMOS
M481  n229       P2         VDD        VDD        PMOS
M482  n229       G1         VDD        VDD        PMOS
M483  n229       P2         n230       GND        NMOS
M484  n230       G1         GND        GND        NMOS
M485  n228       n229       VDD        VDD        PMOS
M486  n228       n229       GND        GND        NMOS
M487  n233       n225       VDD        VDD        PMOS
M488  n232       n228       n233       VDD        PMOS
M489  n232       n225       GND        GND        NMOS
M490  n232       n228       GND        GND        NMOS
M491  n231       n232       VDD        VDD        PMOS
M492  n231       n232       GND        GND        NMOS
M493  n235       P2         VDD        VDD        PMOS
M494  n235       P1         VDD        VDD        PMOS
M495  n235       P2         n236       GND        NMOS
M496  n236       P1         GND        GND        NMOS
M497  n234       n235       VDD        VDD        PMOS
M498  n234       n235       GND        GND        NMOS
M499  n238       n234       VDD        VDD        PMOS
M500  n238       G0         VDD        VDD        PMOS
M501  n238       n234       n239       GND        NMOS
M502  n239       G0         GND        GND        NMOS
M503  n237       n238       VDD        VDD        PMOS
M504  n237       n238       GND        GND        NMOS
M505  n242       n231       VDD        VDD        PMOS
M506  n241       n237       n242       VDD        PMOS
M507  n241       n231       GND        GND        NMOS
M508  n241       n237       GND        GND        NMOS
M509  n240       n241       VDD        VDD        PMOS
M510  n240       n241       GND        GND        NMOS
M511  n244       P2         VDD        VDD        PMOS
M512  n244       P1         VDD        VDD        PMOS
M513  n244       P2         n245       GND        NMOS
M514  n245       P1         GND        GND        NMOS
M515  n243       n244       VDD        VDD        PMOS
M516  n243       n244       GND        GND        NMOS
M517  n247       n243       VDD        VDD        PMOS
M518  n247       P0         VDD        VDD        PMOS
M519  n247       n243       n248       GND        NMOS
M520  n248       P0         GND        GND        NMOS
M521  n246       n247       VDD        VDD        PMOS
M522  n246       n247       GND        GND        NMOS
M523  n249       Cn         VDD        VDD        PMOS
M524  n249       Cn         GND        GND        NMOS
M525  n251       n246       VDD        VDD        PMOS
M526  n251       n249       VDD        VDD        PMOS
M527  n251       n246       n252       GND        NMOS
M528  n252       n249       GND        GND        NMOS
M529  n250       n251       VDD        VDD        PMOS
M530  n250       n251       GND        GND        NMOS
M531  n255       n240       VDD        VDD        PMOS
M532  n254       n250       n255       VDD        PMOS
M533  n254       n240       GND        GND        NMOS
M534  n254       n250       GND        GND        NMOS
M535  n253       n254       VDD        VDD        PMOS
M536  n253       n254       GND        GND        NMOS
M537  n256       n253       VDD        VDD        PMOS
M538  n256       n253       GND        GND        NMOS
M539  n257       n256       VDD        VDD        PMOS
M540  n257       n256       GND        GND        NMOS
M541  C3         n257       VDD        VDD        PMOS
M542  C3         n257       GND        GND        NMOS
M543  n259       P3         VDD        VDD        PMOS
M544  n259       G2         VDD        VDD        PMOS
M545  n259       P3         n260       GND        NMOS
M546  n260       G2         GND        GND        NMOS
M547  n258       n259       VDD        VDD        PMOS
M548  n258       n259       GND        GND        NMOS
M549  n263       G3         VDD        VDD        PMOS
M550  n262       n258       n263       VDD        PMOS
M551  n262       G3         GND        GND        NMOS
M552  n262       n258       GND        GND        NMOS
M553  n261       n262       VDD        VDD        PMOS
M554  n261       n262       GND        GND        NMOS
M555  n265       P3         VDD        VDD        PMOS
M556  n265       P2         VDD        VDD        PMOS
M557  n265       P3         n266       GND        NMOS
M558  n266       P2         GND        GND        NMOS
M559  n264       n265       VDD        VDD        PMOS
M560  n264       n265       GND        GND        NMOS
M561  n268       n264       VDD        VDD        PMOS
M562  n268       G1         VDD        VDD        PMOS
M563  n268       n264       n269       GND        NMOS
M564  n269       G1         GND        GND        NMOS
M565  n267       n268       VDD        VDD        PMOS
M566  n267       n268       GND        GND        NMOS
M567  n272       n261       VDD        VDD        PMOS
M568  n271       n267       n272       VDD        PMOS
M569  n271       n261       GND        GND        NMOS
M570  n271       n267       GND        GND        NMOS
M571  n270       n271       VDD        VDD        PMOS
M572  n270       n271       GND        GND        NMOS
M573  n274       P3         VDD        VDD        PMOS
M574  n274       P2         VDD        VDD        PMOS
M575  n274       P3         n275       GND        NMOS
M576  n275       P2         GND        GND        NMOS
M577  n273       n274       VDD        VDD        PMOS
M578  n273       n274       GND        GND        NMOS
M579  n277       n273       VDD        VDD        PMOS
M580  n277       P1         VDD        VDD        PMOS
M581  n277       n273       n278       GND        NMOS
M582  n278       P1         GND        GND        NMOS
M583  n276       n277       VDD        VDD        PMOS
M584  n276       n277       GND        GND        NMOS
M585  n280       n276       VDD        VDD        PMOS
M586  n280       G0         VDD        VDD        PMOS
M587  n280       n276       n281       GND        NMOS
M588  n281       G0         GND        GND        NMOS
M589  n279       n280       VDD        VDD        PMOS
M590  n279       n280       GND        GND        NMOS
M591  n284       n270       VDD        VDD        PMOS
M592  n283       n279       n284       VDD        PMOS
M593  n283       n270       GND        GND        NMOS
M594  n283       n279       GND        GND        NMOS
M595  n282       n283       VDD        VDD        PMOS
M596  n282       n283       GND        GND        NMOS
M597  n285       n282       VDD        VDD        PMOS
M598  n285       n282       GND        GND        NMOS
M599  n286       n285       VDD        VDD        PMOS
M600  n286       n285       GND        GND        NMOS
M601  Y_OUT      n286       VDD        VDD        PMOS
M602  Y_OUT      n286       GND        GND        NMOS
M603  n289       M          VDD        VDD        PMOS
M604  n288       G0         n289       VDD        PMOS
M605  n288       M          GND        GND        NMOS
M606  n288       G0         GND        GND        NMOS
M607  n287       n288       VDD        VDD        PMOS
M608  n287       n288       GND        GND        NMOS
M609  n290       Cn         VDD        VDD        PMOS
M610  n290       Cn         GND        GND        NMOS
M611  n292       P0         VDD        VDD        PMOS
M612  n292       n290       VDD        VDD        PMOS
M613  n292       P0         n293       GND        NMOS
M614  n293       n290       GND        GND        NMOS
M615  n291       n292       VDD        VDD        PMOS
M616  n291       n292       GND        GND        NMOS
M617  n296       n287       VDD        VDD        PMOS
M618  n295       n291       n296       VDD        PMOS
M619  n295       n287       GND        GND        NMOS
M620  n295       n291       GND        GND        NMOS
M621  n294       n295       VDD        VDD        PMOS
M622  n294       n295       GND        GND        NMOS
M623  n297       n294       VDD        VDD        PMOS
M624  n297       n294       GND        GND        NMOS
M625  n298       n297       VDD        VDD        PMOS
M626  n298       n297       GND        GND        NMOS
M627  C1         n298       VDD        VDD        PMOS
M628  C1         n298       GND        GND        NMOS
M629  n300       P3         VDD        VDD        PMOS
M630  n300       C3         VDD        VDD        PMOS
M631  n300       P3         n303       GND        NMOS
M632  n303       C3         GND        GND        NMOS
M633  n301       P3         VDD        VDD        PMOS
M634  n301       n300       VDD        VDD        PMOS
M635  n301       P3         n304       GND        NMOS
M636  n304       n300       GND        GND        NMOS
M637  n302       C3         VDD        VDD        PMOS
M638  n302       n300       VDD        VDD        PMOS
M639  n302       C3         n305       GND        NMOS
M640  n305       n300       GND        GND        NMOS
M641  n299       n301       VDD        VDD        PMOS
M642  n299       n302       VDD        VDD        PMOS
M643  n299       n301       n306       GND        NMOS
M644  n306       n302       GND        GND        NMOS
M645  n307       n299       VDD        VDD        PMOS
M646  n307       n299       GND        GND        NMOS
M647  F3         n307       VDD        VDD        PMOS
M648  F3         n307       GND        GND        NMOS
M649  n309       P1         VDD        VDD        PMOS
M650  n309       C1         VDD        VDD        PMOS
M651  n309       P1         n312       GND        NMOS
M652  n312       C1         GND        GND        NMOS
M653  n310       P1         VDD        VDD        PMOS
M654  n310       n309       VDD        VDD        PMOS
M655  n310       P1         n313       GND        NMOS
M656  n313       n309       GND        GND        NMOS
M657  n311       C1         VDD        VDD        PMOS
M658  n311       n309       VDD        VDD        PMOS
M659  n311       C1         n314       GND        NMOS
M660  n314       n309       GND        GND        NMOS
M661  n308       n310       VDD        VDD        PMOS
M662  n308       n311       VDD        VDD        PMOS
M663  n308       n310       n315       GND        NMOS
M664  n315       n311       GND        GND        NMOS
M665  n316       n308       VDD        VDD        PMOS
M666  n316       n308       GND        GND        NMOS
M667  F1         n316       VDD        VDD        PMOS
M668  F1         n316       GND        GND        NMOS
M669  n318       P2         VDD        VDD        PMOS
M670  n318       C2         VDD        VDD        PMOS
M671  n318       P2         n321       GND        NMOS
M672  n321       C2         GND        GND        NMOS
M673  n319       P2         VDD        VDD        PMOS
M674  n319       n318       VDD        VDD        PMOS
M675  n319       P2         n322       GND        NMOS
M676  n322       n318       GND        GND        NMOS
M677  n320       C2         VDD        VDD        PMOS
M678  n320       n318       VDD        VDD        PMOS
M679  n320       C2         n323       GND        NMOS
M680  n323       n318       GND        GND        NMOS
M681  n317       n319       VDD        VDD        PMOS
M682  n317       n320       VDD        VDD        PMOS
M683  n317       n319       n324       GND        NMOS
M684  n324       n320       GND        GND        NMOS
M685  n325       n317       VDD        VDD        PMOS
M686  n325       n317       GND        GND        NMOS
M687  F2         n325       VDD        VDD        PMOS
M688  F2         n325       GND        GND        NMOS
M689  n327       F0         VDD        VDD        PMOS
M690  n327       F1         VDD        VDD        PMOS
M691  n327       F0         n328       GND        NMOS
M692  n328       F1         GND        GND        NMOS
M693  n326       n327       VDD        VDD        PMOS
M694  n326       n327       GND        GND        NMOS
M695  n330       n326       VDD        VDD        PMOS
M696  n330       F2         VDD        VDD        PMOS
M697  n330       n326       n331       GND        NMOS
M698  n331       F2         GND        GND        NMOS
M699  n329       n330       VDD        VDD        PMOS
M700  n329       n330       GND        GND        NMOS
M701  n333       n329       VDD        VDD        PMOS
M702  n333       F3         VDD        VDD        PMOS
M703  n333       n329       n334       GND        NMOS
M704  n334       F3         GND        GND        NMOS
M705  n332       n333       VDD        VDD        PMOS
M706  n332       n333       GND        GND        NMOS
M707  n335       n332       VDD        VDD        PMOS
M708  n335       n332       GND        GND        NMOS
M709  A_EQ_B     n335       VDD        VDD        PMOS
M710  A_EQ_B     n335       GND        GND        NMOS
